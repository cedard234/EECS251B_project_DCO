ADE simulation setup
Run mode: Single Run, Sweeps and Corners
Tests:
  project_DCO_tb_1: EECS251B_project_DCO_pnupdate/DCO_tb/schematic, simulator spectre
    Variables: CODE = {From/To}Auto:0:32:31{From/To}
    Outputs: VT("/Vout"); v("/Vout" ?result "pss_fd"); v("/Vout" ?result "pss_td"); OP("/I0/I2/NM24" id); OP("/I0/I2/NM24" "id"); harmonic(xval(getData("/Vout" ?result "pss_fd")) '1); OP("/I0/I2/R0" "i"); OP("/I0/I2/R0" "I"); VT("/I0/I0/Vin"); Jee[Second]:rms; pm0
