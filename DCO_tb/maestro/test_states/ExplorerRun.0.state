ADE simulation setup
Test project_DCO_tb_1: EECS251B_project_DCO_pnupdate/DCO_tb/schematic, simulator spectre
  Models: /home/ff/eecs251b/sky130/sky130_cds/sky130_release_0.0.1/libs/sky130_fd_pr_main/../../models/sky130.lib.spice[tt]
  Variables: CODE = {From/To}Auto:0:32:31{From/To}
  Temperature: 27
  Initial conditions: /I0/I0/net2 = 1; /I0/I0/Vin = 0; /I0/I0/net1 = 0
  Operating points saved: /I0/I2/R0 (i)
  Analysis pss: engine=Shooting fund=2G harms=3 oscana=t p=/Vout n=/gnd! errpreset=conservative
  Analysis pnoise: start=1k stop=800M fund=2G p=/Vout n=/gnd! relharmnum=2 noisetype=sampled
  Output VT("/Vout") (unticked)
  Output v("/Vout" ?result "pss_fd") (unticked)
  Output v("/Vout" ?result "pss_td")
  Output OP("/I0/I2/R0" "i") (unticked)
  Output harmonic(xval(getData("/Vout" ?result "pss_fd")) '1) (unticked)
  Output VT("/I0/I0/Vin") (unticked)
  Output Jee_1M = rfJitter(?result "pnoise_sample_pm0" ?unit "Second" ?from 1e+07 ?to 800000000 ?signalLevel "rms")
  Output Jee[Second]:rms; pm0 = rfJitter(?result "pnoise_sample_pm0" ?unit "Second" ?from 100000 ?to 800000000 ?signalLevel "rms")
  Output Edge Phase Noise; dBc/Hz; pm0 = rfEdgePhaseNoise(?result "pnoise_sample_pm0" ?eventList 'nil)
  Signals: /I0/I0/Vin
