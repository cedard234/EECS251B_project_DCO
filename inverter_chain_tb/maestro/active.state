ADE simulation setup
Test project_inverter_chain_tb_1: EECS251B_project_DCO/inverter_chain_tb/schematic, simulator spectre
  Models: /home/ff/eecs251b/sky130/sky130_cds/sky130_release_0.0.1/libs/sky130_fd_pr_main/../../models/sky130.lib.spice[tt]
  Temperature: 27
  Initial conditions: /I0/Vin = 1.8
  Analysis pss: engine=Shooting fund=4G harms=3 tstab=5n oscana=t p=/Vout n=/gnd! errpreset=conservative skipdc=sigrampup ic=all
  Output Vout = VT("/Vout") (unticked)
  Output Vout_fd = v("/Vout" ?result "pss_fd")
  Output Vout_td = v("/Vout" ?result "pss_td")
  Signals: /Vout
Run mode: Single Run, Sweeps and Corners
