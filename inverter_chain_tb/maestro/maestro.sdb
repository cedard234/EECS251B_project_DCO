ADE simulation setup
Run mode: Single Run, Sweeps and Corners
Tests:
  project_inverter_chain_tb_1: EECS251B_project_DCO/inverter_chain_tb/schematic, simulator spectre
    Outputs: Vout; Vout_fd; Vout_td
