ADE simulation setup
Run mode: Single Run, Sweeps and Corners
Tests:
  project_inverter_tb_1: EECS251B_project_DCO/inverter_tb/schematic, simulator spectre
